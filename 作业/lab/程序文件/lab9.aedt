# Ansys Electronics Desktop project, version 2021.1
materials:
  vacuum: permittivity=1
  air: permittivity=1.0006 permeability=1.0000004

design HFSSDesign1 (HFSS, DrivenModal, model units in)
variables:
  l1 = 1.59in
  w1 = 0.795in
  h1 = 1in
  l2 = 7.95in
  w2 = 3.975in
  h2 = 5.2in
  h3 = 5in
  l4 = 8.8in
  w4 = 4.4in
  h4 = 15in
geometry:
  Box1 [vacuum] = box(corner=(-l1/2, -w1/2, 0in), size=(l1, w1, h1))
  Box2 [vacuum] = box(corner=(-l2/2, -w2/2, h3), size=(l2, w2, h2))
  Box1.uncover_faces(FacesToUncover=Box1.face(+z))
  Polyline1 = polyline((l2/2, -w2/2, h3) (l1/2, -w1/2, h1) (w1, w1/2, h1) (l2/2, w2/2, h3) (l2/2, -w2/2, h3), closed, covered)
  Polyline2 = polyline((l2/2, w2/2, h3) (l1/2, w1/2, h1) (-l1/2, w1/2, h1) (-l2/2, w2/2, h3) (l2/2, w2/2, h3), closed, covered)
  Polyline3 = polyline((l2/2, -w2/2, h3) (l1/2, -w1/2, h1) (-l1/2, -w1/2, h1) (-l2/2, -w2/2, h3) (l2/2, -w2/2, h3), closed, covered)
  Polyline4 = polyline((-l2/2, -w2/2, h3) (-l1/2, -w1/2, h1) (-w1, w1/2, h1) (-l2/2, w2/2, h3) (-l2/2, -w2/2, h3), closed, covered)
  Box2.uncover_faces(FacesToUncover=Box2.face(+z))
  Box2.uncover_faces(FacesToUncover=Box2.face(-z))
  Box3 [air] = box(corner=(-l4/2, -w4/2, 0in), size=(l4, w4, h4))
boundaries and excitations:
  Rad1: Radiation Objects=Box3
  PerfE1: Perfect E Objects=[Box2, Polyline1..Polyline4] Faces=Box1.face(+y, -x, -y, +x)
  1: Wave Port Faces=Box1.face(-z) NumModes=1 Modes{Mode1{IntLine{middle of Box1.edge(6 of 12) -> middle of Box1.edge(8 of 12)} CharImp=Zpi}}
setups:
  Setup1: HfssDriven Frequency=6GHz MaxDeltaS=0.02 MaximumPasses=6 MinimumPasses=1 MinimumConvergedPasses=1 PercentRefinement=30 BasisOrder=1 PortAccuracy=2
    sweep Sweep: 4GHz to 8GHz step 0.01GHz; Type=Fast SaveFields
source amplitudes:
  1:1: 1W 0deg
radiation setups:
  Infinite Sphere1: Infinite Sphere Theta=-180deg..180deg step 2deg Phi=-180deg..180deg step 2deg
reports:
  S Parameter Plot 1: dB(S(1,1)) vs Freq on Setup1 : Sweep; markers m1 at 4.46GHz, m2 at 4.93GHz, m3 at 5.51GHz, m4 at 6GHz, m5 at 6.09GHz, m6 at 6.74GHz, m7 at 7.06GHz
  Gain Plot 2: dB(GainTotal) vs Theta on Setup1 : Sweep, Infinite Sphere1 [Phi=0deg Freq=4.46GHz]
  Gain Plot 3: dB(GainTotal) vs Theta on Setup1 : Sweep, Infinite Sphere1 [Phi=0deg Freq=4.93GHz]
  Gain Plot 4: dB(GainTotal) vs Theta on Setup1 : Sweep, Infinite Sphere1 [Phi=0deg Freq=5.51GHz]
  Gain Plot 5: dB(GainTotal) vs Theta on Setup1 : Sweep, Infinite Sphere1 [Phi=0deg Freq=6GHz]
  Gain Plot 6: dB(GainTotal) vs Theta on Setup1 : Sweep, Infinite Sphere1 [Phi=0deg Freq=6.09GHz]
  Gain Plot 7: dB(GainTotal) vs Theta on Setup1 : Sweep, Infinite Sphere1 [Phi=0deg Freq=6.74GHz]
  Gain Plot 8: dB(GainTotal) vs Theta on Setup1 : Sweep, Infinite Sphere1 [Phi=0deg Freq=7.06GHz]
  Gain Plot 9: dB(GainTotal) vs Theta on Setup1 : Sweep, Infinite Sphere1 [Phi=90deg Freq=4.46GHz]
  Gain Plot 10: dB(GainTotal) vs Theta on Setup1 : Sweep, Infinite Sphere1 [Phi=90deg Freq=4.93GHz]
  Gain Plot 11: dB(GainTotal) vs Theta on Setup1 : Sweep, Infinite Sphere1 [Phi=90deg Freq=5.51GHz]
  Gain Plot 12: dB(GainTotal) vs Theta on Setup1 : Sweep, Infinite Sphere1 [Phi=90deg Freq=6GHz]
  Gain Plot 13: dB(GainTotal) vs Theta on Setup1 : Sweep, Infinite Sphere1 [Phi=90deg Freq=6.09GHz]
  Gain Plot 14: dB(GainTotal) vs Theta on Setup1 : Sweep, Infinite Sphere1 [Phi=90deg Freq=6.74GHz]
  Gain Plot 15: dB(GainTotal) vs Theta on Setup1 : Sweep, Infinite Sphere1 [Phi=90deg Freq=7.06GHz]
  Gain Plot 16: dB(GainTotal) vs Phi, Theta on Setup1 : LastAdaptive, Infinite Sphere1 [Freq=6GHz]
